* 09-repeated-detach-remate: Repeated detach / remate stays branch-off while moving
* Issue 24 UNVERIFIED screening deck. Not qualification.
.title 09-repeated-detach-remate
.include models/power_control.inc
V_VIN vin_src 0 DC {v_in}
V_Q1A_SHORT q1a_short 0 DC 0.0
V_Q1B_SHORT q1b_short 0 DC 0.0
V_Q1_OPEN q1_open 0 DC 0.0
V_DCHG_OPEN dchg_open 0 DC 0.0
V_P08_FORCE p08_force 0 DC 0.0
V_LOAD_SHORT load_short 0 DC 0.0
V_S1_CTRL s1_ctrl 0 PWL(0 0.0 0.005 0.0 0.0052 3.3 0.012 3.3 0.0122 0.0 0.022 0.0 0.0222 3.3 0.03 3.3 0.0302 0.0 0.04 0.0)
V_S2_CTRL s2_ctrl 0 PWL(0 0.0 0.006 0.0 0.0062 3.3 0.031 3.3 0.0312 0.0 0.04 0.0)
V_P03_MAKE p03_make 0 PWL(0 0.0 0.002 0.0 0.0022 3.3 0.016 3.3 0.0162 0.0 0.02 0.0 0.0202 3.3 0.034 3.3 0.0342 0.0 0.04 0.0)
V_P04_MAKE p04_make 0 PWL(0 0.0 0.002 0.0 0.0022 3.3 0.016 3.3 0.0162 0.0 0.02 0.0 0.0202 3.3 0.034 3.3 0.0342 0.0 0.04 0.0)
V_P01_MAKE p01_make 0 PWL(0 0.0 0.003 0.0 0.0032 3.3 0.016 3.3 0.0162 0.0 0.021 0.0 0.0212 3.3 0.034 3.3 0.0342 0.0 0.04 0.0)
V_P02_MAKE p02_make 0 PWL(0 0.0 0.003 0.0 0.0032 3.3 0.016 3.3 0.0162 0.0 0.021 0.0 0.0212 3.3 0.034 3.3 0.0342 0.0 0.04 0.0)
V_B50_GND_MAKE b50_gnd_make 0 PWL(0.0 0.0 0.00198 0.0 0.002 3.3 0.03598 3.3 0.036 0.0 0.04 0.0)
V_B50_VIN_MAKE b50_vin_make 0 PWL(0.0 0.0 0.00298 0.0 0.003 3.3 0.03598 3.3 0.036 0.0 0.04 0.0)
.tran 20u 0.04
.control
run
set wr_singlescale
set wr_vecnames
wrdata results/09-repeated-detach-remate.dat v(q1_en) v(v_branch) v(interlock_ok) v(remate_req) v(latch) v(iso_en) v(p08_diag) v(sda_rail) v(sda_br) v(vin_shared) v(s1_ctrl) v(s2_ctrl) v(i_sns) v(oc)
quit
.endc
.end
